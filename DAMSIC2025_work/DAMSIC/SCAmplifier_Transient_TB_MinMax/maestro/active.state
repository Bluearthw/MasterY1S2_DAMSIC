ADE simulation setup
Test DAMSIC_SCAmplifier_TranTB_MinMax_1: DAMSIC/SCAmplifier_Transient_TB_MinMax/schematic, simulator spectre
  Models: /esat/micas-data/data/design/generic/045/gpdk045_v_4_0/gpdk045/../models/spectre/gpdk045.scs[mc]
  Variables: RSW_OFF = 100M; RSW_ON = 10; VSW_TH = 0.55; C_OTA = 0.5p; gm_OTA = 20m; ro_OTA = 50K; alpha = 0.01; Vmax = 100m; Vmin = 50m; Cfb = 1p; Cin = 8p; Cl = 1p; fsw = 1M; INCM = 0.55; OUTCMRef = 0.55; vdd = 1.1
  Temperature: 27
  Analysis tran: stop=6/VAR("fsw") errpreset=conservative
  Signals: /phi<1>, /phi<2>, /VinP, /VinN, /INP, /INN, /OUTN, /OUTP, /VoutN, /VoutP, /OUTDM, /INDM, /INNDM
Run mode: Single Run, Sweeps and Corners
Setup values for test DAMSIC_SCAmplifier_TranTB_MinMax_1: Cfb = 0.5p; Cin = 5p; Cl = 2.5p; fsw = 80k; CP2 = 1/(6.28*1.1G)
