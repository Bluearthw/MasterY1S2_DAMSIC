ADE simulation setup
Run mode: Single Run, Sweeps and Corners
Tests:
  DAMSIC_SCAmplifier_TranTB_MinMax_1: DAMSIC/SCAmplifier_Transient_TB_MinMax/schematic, simulator spectre
    Variables: Cfb = 0.5p; Cin = 5p; Cl = 2.5p; fsw = 80k; RSW_OFF = 100M; RSW_ON = 10; VSW_TH = 0.55; INCM = 0.55; OUTCMRef = 0.55; vdd = 1.1; Vmax = 100m; Vmin = 50m; alpha = 0.01; C_OTA = 0.5p; gm_OTA = 20m; ro_OTA = 50K; CP2 = 1/(6.28*1.1G)
