ADE simulation setup
Run mode: Single Run, Sweeps and Corners
Tests:
  DAMSIC_demo_SCAmplifier_idealOTA_STB_TB_1: DAMSIC/demo_SCAmplifier_idealOTA_STB_TB/schematic, simulator spectre
    Variables: Cfb = 0.5; Cin = 5; Cl = 2.5; INCM = 0.5; OUTCMRef = 0.5; vdd = 1.1; gm_ota = 11.3m; ro_ota = 1.11M; c_ota = 0.5p
