ADE simulation setup
Test DAMSIC_demo_SCAmplifier_idealOTA_STB_TB_1: DAMSIC/demo_SCAmplifier_idealOTA_STB_TB/schematic, simulator spectre
  Models: /esat/micas-data/data/design/generic/045/gpdk045_v_4_0/gpdk045/../models/spectre/gpdk045.scs[mc]
  Variables: c_ota = 0.5p; gm_ota = 11.3m; ro_ota = 1.11M; Cfb = 0.5; Cin = 5; Cl = 2.5; INCM = 0.5; OUTCMRef = 0.5; vdd = 1.1
  Temperature: 27
  Analysis stb: start=1 stop=10G dec=20 probe=/I23 stbProbeMode=differential
  Output Loop Gain Phase = phaseDegUnwrapped(getData("loopGain" ?result "stb"))
  Output Loop Gain dB20 = db(mag(getData("loopGain" ?result "stb")))
Run mode: Single Run, Sweeps and Corners
