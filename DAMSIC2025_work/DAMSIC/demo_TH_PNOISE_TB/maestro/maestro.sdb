ADE simulation setup
Run mode: Single Run, Sweeps and Corners
Tests:
  PSS_PNOISE: DAMSIC/demo_TH_PNOISE_TB/schematic, simulator spectre
    Variables: CSAMP = 1p; F_CLK = 10M; F_IN = 0; MULT_NMOS = 1; vdd = 1.1
    Outputs: Single Integrated Noise (V)
