ADE simulation setup
Test DAMSIC_OTA_Transient_AC_TB_1: DAMSIC/OTA_Transient_AC_TB/schematic, simulator spectre
  Models: /esat/micas-data/data/design/generic/045/gpdk045_v_4_0/gpdk045/../models/spectre/gpdk045.scs[mc]
  Variables: CP2 = 1/(6.28*1.1G); Cl = 2.5p; FreqIn = 1K; INCM = 0.55; INDM = 0.05; OUTCMREF = 0.55; gm = 25m; ro = 0.7M
  Temperature: 27
  Analysis ac: start=1 stop=10G dec=10
  Output v /OUTDM; ac dB20(V) = db(vfreq('ac "/OUTDM"))
  Output v /OUTDM; ac deg(V) = phaseDegUnwrapped(vfreq('ac "/OUTDM"))
  Signals: /OUTN, /OUTP, /INP, /INN, /OUTDM
Run mode: Single Run, Sweeps and Corners
