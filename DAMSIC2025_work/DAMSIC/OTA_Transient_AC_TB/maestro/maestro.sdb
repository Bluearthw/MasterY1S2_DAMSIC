ADE simulation setup
Run mode: Single Run, Sweeps and Corners
Tests:
  DAMSIC_OTA_Transient_AC_TB_1: DAMSIC/OTA_Transient_AC_TB/schematic, simulator spectre
    Variables: Cl = 2.5p; FreqIn = 1K; INCM = 0.55; INDM = 0.05; OUTCMREF = 0.55; gm = 25m; ro = 0.7M; CP2 = 1/(6.28*1.1G)
