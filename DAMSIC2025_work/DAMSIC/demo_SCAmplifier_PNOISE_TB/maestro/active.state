ADE simulation setup
Test PSS_PNOISE: DAMSIC/demo_SCAmplifier_PNOISE_TB/schematic, simulator spectre
  Models: /esat/micas-data/data/design/generic/045/gpdk045_v_4_0/gpdk045/../models/spectre/gpdk045.scs[mc]
  Variables: CP2 = 1/(6.28*1.1G); alpha = 0.01; Cfb = 0.5p; Cin = 5p; Cl = 2.5p; fin = 0; fsw = 80M; gm_OTA = 25m; C_OTA = 0.5p; ro_OTA = 0.7M; INCM = 0.55; OUTCMRef = 0.55; ron = 5; vdd = 1.1; Vin = 0
  Temperature: 27
  Analysis pss: engine=Shooting fund=80M harms=200
  Analysis pnoise: start=1 stop=VAR("fsw")/2 dec=15 fund=80M noisetype=sampled
  Output v /phi<2>; pss (V) = vtime('pss "/phi<2>")
  Output Output Noise (V/sqrt(Hz)) = getData("out" ?result "pnoise_sample_pm0")
  Output Integrated Noise (V) = pow(integ(pow(clip(getData("out" ?result "pnoise_sample_pm0") 10 35000000) 2)) 0.5)
  Output v /VoutP; pss (V) = vtime('pss "/VoutP") (unticked)
  Output v (/VoutP /VoutN); pss (V) = (vtime('pss "/VoutP") - vtime('pss "/VoutN")) (unticked)
  Signals: /OUTDM
Run mode: Single Run, Sweeps and Corners
Setup values for test PSS_PNOISE: Cfb = 0.2p; Cin = 2p; Cl = 3p; fsw = 70M; gm_OTA = 20m; ro_OTA = 1M; INCM = 0.5; OUTCMRef = 0.5
