ADE simulation setup
Run mode: Single Run, Sweeps and Corners
Tests:
  PSS_PNOISE: DAMSIC/demo_SCAmplifier_PNOISE_TB/schematic, simulator spectre
    Variables: alpha = 0.01; Cfb = 0.5p; Cin = 5p; Cl = 2.5p; fin = 0; fsw = 80M; gm_OTA = 25m; C_OTA = 0.5p; ro_OTA = 0.7M; INCM = 0.55; OUTCMRef = 0.55; ron = 5; vdd = 1.1; Vin = 0; CP2 = 1/(6.28*1.1G)
