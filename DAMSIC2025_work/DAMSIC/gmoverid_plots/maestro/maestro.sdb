ADE simulation setup
Run mode: Single Run, Sweeps and Corners
Tests:
  DAMSIC_2023_gmoverid_plots_1: DAMSIC/gmoverid_plots/schematic, simulator spectre
    Variables: VSBn = 0; Ln = 45n*5; NFn = 55; WFn = 20*120n; VGSn = 0.5; VDSn = 0.15; Lp = 45n*10; NFp = 52; WFp = 20*120n; VGSp = -500m; VDSp = -0.275; VSBp = 0
    Outputs: IDn; |IDp|; gm,n; gm,p; gm/ID,p; gm/ID,n; fT,n; fT,p; (Aintr,n)dB; (Aintr,p)dB; fT,n*Aintr,n; fT,p*Aintr,p; gm,n vs gm/ID,n; gm,p vs gm/ID,p; fT,n vs gm/ID,n; fT,p vs gm/ID,p; Aintr,n vs gm/ID,n; Aintr,p vs gm/ID,p; fT,n*Aintr,n vs gm/ID,n; fT,p*Aintr,p vs gm/ID,p; ID,n/W vs gm/ID,n; |ID,p|/W vs gm/ID,p; OS("/NM0" "gm"); Vth,n; |Vth,p|; 1/gds,n; 1/gds,p; 1/gds,n vs gm/ID,n; 1/gds,p vs gm/ID,p
Global variables:
  Ln = 45n
Specs:
  DAMSIC_2023_gmoverid_plots_1 / Vgt,p: < abs(VAR("VDSp"))
