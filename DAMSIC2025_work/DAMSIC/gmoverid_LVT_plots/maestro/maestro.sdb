ADE simulation setup
Run mode: Single Run, Sweeps and Corners
Tests:
  DAMSIC_gmoverid_LVT_plots_1: DAMSIC/gmoverid_LVT_plots/schematic, simulator spectre
    Variables: VSBn = 0; Ln = 45n; NFn = 1; WFn = 120n*20; VGSn = 0.42; VDSn = 0.22; Lp = 45n; NFp = 1; WFp = 120n*20; VGSp = -400m; VDSp = -200m; VSBp = 0
