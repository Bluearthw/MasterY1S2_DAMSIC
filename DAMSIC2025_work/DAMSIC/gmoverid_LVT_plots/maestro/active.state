ADE simulation setup
Test DAMSIC_gmoverid_LVT_plots_1: DAMSIC/gmoverid_LVT_plots/schematic, simulator spectre
  Models: /esat/micas-data/data/design/generic/045/gpdk045_v_4_0/gpdk045/../models/spectre/gpdk045.scs[mc]
  Variables: VSBn = 0; Ln = 45n; NFn = 1; WFn = 120n*20; VGSn = 0.42; VDSn = 0.22; Lp = 45n; NFp = 1; WFp = 120n*20; VGSp = -400m; VDSp = -200m; VSBp = 0
  Temperature: 27
  Analysis dc: sweep VGSp start=-1 stop=0 step=10m (saves the operating point)
Run mode: Single Run, Sweeps and Corners
