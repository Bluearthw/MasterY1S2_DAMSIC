ADE simulation setup
Run mode: Single Run, Sweeps and Corners
Tests:
  DAMSIC_SwitchedCapacitorAmplifier_TransientTestBench_1: DAMSIC/SCAmplifier_Transient_TB/schematic, simulator spectre
    Variables: alpha = 0.01; Cfb = 0.5p; Cin = 5p; Cl = 2.5p; fin = VAR("fsw")/2; fsw = 80M; OUTCMRef = 0.55; vdd = 1.1; Vin = 100m; INCM = 0.55; C_OTA = 0.5p; gm_OTA = 22.4m; ro_OTA = 0.55M; RSW_OFF = 100M; RSW_ON = 1; VSW_TH = 0.55; CP2 = 1/(6.28*1.1G)
    Outputs: (((VT("/INDM") * 10) - VT("/OUTDM")) / (VT("/INDM") * 10)); (((VT("/INDM") * 10) + VT("/OUTDM")) / (VT("/INDM") * 10)); (((VT("/INDM") * 10) + VT("/OUTDM")) / (VT("/INDM")))
