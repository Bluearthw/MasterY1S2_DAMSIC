ADE simulation setup
Run mode: Single Run, Sweeps and Corners
Tests:
  DAMSIC_SwitchedCapacitorAmplifier_TransientTestBench_1: DAMSIC/SCAmplifier_Transient_TB/schematic, simulator spectre
    Variables: alpha = 0.01; Cfb = 0.5p; Cin = 5.5p; Cl = 2.7p; fin = 100K; fsw = 80M; OUTCMRef = 0.5; vdd = 1.1; Vin = 100m; INCM = 0.5; C_OTA = 0.5p; gm_OTA = 20m; ro_OTA = 50k; RSW_OFF = 100M; RSW_ON = 1; VSW_TH = 0.55
