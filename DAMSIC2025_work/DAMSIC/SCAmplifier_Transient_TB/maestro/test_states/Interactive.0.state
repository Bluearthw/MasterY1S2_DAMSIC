ADE simulation setup
Test DAMSIC_SwitchedCapacitorAmplifier_TransientTestBench_1: DAMSIC/SCAmplifier_Transient_TB/schematic, simulator spectre
  Models: /esat/micas-data/data/design/generic/045/gpdk045_v_4_0/gpdk045/../models/spectre/gpdk045.scs[mc]
  Variables: CP2 = 1/(6.28*1.1G); RSW_OFF = 100M; RSW_ON = 1; VSW_TH = 0.55; C_OTA = 0.5p; gm_OTA = 22.4m; ro_OTA = 0.55M; INCM = 0.55; alpha = 0.01; Cfb = 0.5p; Cin = 5p; Cl = 2.5p; fsw = 80M; OUTCMRef = 0.55; vdd = 1.1; Vin = 100m; fin = "VAR(\"fsw\")/2"
  Temperature: 27
  Analysis ac: start=1 stop=1G dec=10
  Output (((VT("/INDM") * 10) + VT("/OUTDM")) / (VT("/INDM"))) (unticked)
  Output v /OUTDM; ac dB20(V) = db(vfreq('ac "/OUTDM"))
  Output v /OUTDM; ac deg(V) = phaseDegUnwrapped(vfreq('ac "/OUTDM"))
  Signals: /phi<1>, /phi<2>, /INDM, /OUTDM, /OUTCM, /INCM
