ADE simulation setup
Test DAMSIC_SwitchedCapacitorAmplifier_TransientTestBench_1: DAMSIC/SCAmplifier_Transient_TB/schematic, simulator spectre
  Models: /esat/micas-data/data/design/generic/045/gpdk045_v_4_0/gpdk045/../models/spectre/gpdk045.scs[mc]
  Variables: CP2 = 1/(6.28*1.1G); RSW_OFF = 100M; RSW_ON = 1; VSW_TH = 0.55; C_OTA = 0.5p; gm_OTA = 22.4m; ro_OTA = 0.55M; INCM = 0.55; alpha = 0.01; Cfb = 0.5p; Cin = 5p; Cl = 2.5p; fsw = 80M; OUTCMRef = 0.55; vdd = 1.1; Vin = 100m; fin = "VAR(\"fsw\")/2"
  Temperature: 27
  Analysis tran: stop=5/VAR("fin") errpreset=conservative
  Output (((VT("/INDM") * 10) + VT("/OUTDM")) / (VT("/INDM"))) (unticked)
  Output v /OUTDM; ac dB20(V) = db(vfreq('ac "/OUTDM")) (unticked)
  Output v /OUTDM; ac deg(V) = phaseDegUnwrapped(vfreq('ac "/OUTDM")) (unticked)
  Signals: /phi<1>, /phi<2>, /INDM, /OUTDM, /OUTCM, /INCM
Run mode: Single Run, Sweeps and Corners
Setup values for test DAMSIC_SwitchedCapacitorAmplifier_TransientTestBench_1: Cin = 5.5p; Cl = 2.7p; fin = 100K; OUTCMRef = 0.5; INCM = 0.5; gm_OTA = 20m; ro_OTA = 50k
