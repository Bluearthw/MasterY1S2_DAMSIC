ADE simulation setup
Test STB: DAMSIC/demo_SCAmplifier_STB_TB/schematic, simulator spectre
  Models: /esat/micas-data/data/design/generic/045/gpdk045_v_4_0/gpdk045/../models/spectre/gpdk045.scs[mc]
  Variables: Cfb = 0.2p; Cin = 2p; Cl = 2p; gm_OTA = 25m; ro_OTA = 2.5M; C_OTA = 1p; F_POLE2 = 1G; INCM = 0.5; OUTCMRef = 0.5; ron = 5; vdd = 1.1; F_CLK = 1M; CP2 = 1/(6.28*F_POLE2)
  Temperature: 27
  Analysis pss: engine=Shooting fund=VAR("F_CLK") harms=200
  Analysis pnoise: start=1 dec=20 fund=VAR("F_CLK") noisetype=sampled
  Analysis stb: start=1 stop=100G dec=20 probe=/I23 stbProbeMode=differential
  Output Loop Gain Phase = phaseDegUnwrapped(getData("loopGain" ?result "stb"))
  Output Loop Gain dB20 = db(mag(getData("loopGain" ?result "stb")))
  Output Integrated Noise (V) = pow(integ(pow(clip(getData("out" ?result "pnoise_sample_pm0") 1 500000) 2)) 0.5)
Run mode: Single Run, Sweeps and Corners
Setup values for test STB: Cfb = 0.5p; Cin = 5p; Cl = 2.5p; ro_OTA = 580k; C_OTA = 0.1p; F_POLE2 = 1.1G; INCM = 0.55; OUTCMRef = 0.55
