ADE simulation setup
Test damsicOurs_SOTA_SCAmplifier_Transient_TB_MinMax_1: damsicOurs/SOTA_SCAmplifier_Transient_TB_MinMax/schematic, simulator spectre
  Models: /esat/micas-data/data/design/generic/045/gpdk045_v_4_0/gpdk045/../models/spectre/gpdk045.scs[mc]
  Variables: A = 2; r_cmfb = 100; B = 2; Cfb = 0.5p; Cin = 5p; Cl = 2.5p; alpha = 0.01; fsw = 80M; RSW_OFF = 100M; RSW_ON = 10; Vmax = 50m; Vmin = 25m; VSW_TH = 0.55; nL = 5; nL1 = 5; nl2 = 5; nl3 = 3; nL7 = 5; nnF4 = 40; nnF5 = 150; npF1 = 181; npF2 = 150; npF6 = 200; npF7 = 170; nnW3 = 20; nnW5 = 20; npW1 = 20; npW2 = 20; npW6 = 20; npW7 = 20; INCM = 0.55; OUTCMRef = 0.55; vdd = 1.1; vb1 = 0.58; vb5 = 0.84; vb6 = 0.29; vb7 = 0.59
  Temperature: 27
  Analysis tran: stop=5/VAR("fsw") errpreset=conservative
  Output error = ((1 - abs((VT("/OUTDM") / VT("/INDM") / 10))) * 100)
  Signals: /INDM, /OUTDM, /OUTCM, /phi<1>
Run mode: Single Run, Sweeps and Corners
