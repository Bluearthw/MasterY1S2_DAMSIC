ADE simulation setup
Test damsicOurs_GBOTA_SCAmplifier_PNOISE_TB_1: damsicOurs/GBOTA_SCAmplifier_PNOISE_TB/schematic, simulator spectre
  Models: /esat/micas-data/data/design/generic/045/gpdk045_v_4_0/gpdk045/../models/spectre/gpdk045.scs[mc]
  Variables: VSW_TH = 0.55; Vmin = 25m; Vmax = 50m; RSW_ON = 10; RSW_OFF = 100M; GB2_vb7 = 0.47; GB2_vb6 = 0.21; GB2_vb5 = 0.65; GB2_vb3 = 0.45; GB2_vb1 = 0.613; GB2_npW7 = 20; GB2_npW6 = 20; GB2_npW2 = 20; GB2_npW1 = 20; GB2_nnW5 = 20; GB2_nnW3 = 20; GB2_npF7 = 53; GB2_npF6 = 203; GB2_npF2 = 88; GB2_npF1 = 53; GB2_nnF5 = 263; GB2_nnF3 = 213; GB2_nL7 = 3; GB2_nL6 = 9; GB2_nL5 = 9; GB2_nl3 = 9; GB2_nl2 = 9; GB2_nL1 = 6; GB2_Cl = 5p; GB2_r_cmfb = 200; GB2_A = 3; GB1_vb7 = 0.6; GB1_vb6 = 0.52; GB1_vb5 = 0.82; GB1_vb3 = 0.59; GB1_vb1 = 0.52; GB1_r_cmfb = 200; GB1_Cl = 5p; GB1_A = 3; GB1_npW7 = 20; GB1_npW6 = 20; GB1_npW2 = 20; GB1_npW1 = 20; GB1_nnW5 = 20; GB1_nnW3 = 20; GB1_npF7 = 222; GB1_npF6 = 222; GB1_npF2 = 199; GB1_npF1 = 100; GB1_nnF5 = 150; GB1_nnF3 = 52; GB1_nL7 = 4; GB1_nL6 = 4; GB1_nL5 = 5; GB1_nL3 = 3; GB1_nl2 = 5; GB1_nL1 = 6; OUTCMREF = 0.55; INDM = 0.05; FreqIn = 1k; A = 2; alpha = 0.01; B = 2; Cfb = 0.5p; Cin = 5.14p; Cl = 2.5p; fin = 2M; fsw = 80M; gm_GB = 10m; ro_GB = 10k; r_cmfb = 100; nL = 5; nL1 = 5; nl2 = 5; nl3 = 5; nL7 = 5; nnF4 = 40; nnF5 = 150; npF1 = 181; npF2 = 190; npF6 = 200; npF7 = 170; npW1 = 20; npW2 = 20; npW6 = 20; npW7 = 20; nnW3 = 20; nnW5 = 20; INCM = 0.55; OUTCMRef = 0.55; vb1 = 0.58; vb5 = 0.84; vb6 = 0.29; vb7 = 0.59; vdd = 1.1; Vin = 0
  Temperature: 27
  Analysis pnoise: start=1 stop=VAR("fsw")/2 dec=15 fund=80M noisetype=sampled
  Analysis pss: engine=Shooting fund=80M harms=200
  Output Output Noise (V/sqrt(Hz)) = getData("out" ?result "pnoise_sample_pm0")
  Output Integrated Noise (V) = pow(integ(pow(clip(getData("out" ?result "pnoise_sample_pm0") 1 40000000) 2)) 0.5)
  Output v /phi<2>; pss (V) = vtime('pss "/phi<2>")
Run mode: Single Run, Sweeps and Corners
