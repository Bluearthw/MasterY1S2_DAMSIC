ADE simulation setup
Run mode: Single Run, Sweeps and Corners
Tests:
  damsicOurs_SOTA_Transient_AC_TB_1: damsicOurs/SOTA_Transient_AC_TB/schematic, simulator spectre
    Variables: A = 2; r_cmfb = 100; B = 2; Cl = 2.5p; FreqIn = 1k; INDM = 0.05; nL = 5; nL1 = 5; nl2 = 5; nl3 = 3; nL7 = 5; nnF4 = 40; nnF5 = 150; npF1 = 181; npF2 = 150; npF6 = 200; npF7 = 170; npW1 = 20; npW2 = 20; npW6 = 20; npW7 = 20; nnW3 = 20; nnW5 = 20; INCM = 0.55; OUTCMREF = 0.55; vdd = 1.1; vb1 = 0.58; vb5 = 0.84; vb6 = 0.29; vb7 = 0.59
