ADE simulation setup
Test damsicOurs_SOTA_SCAmplifier_PNOISE_TB_1: damsicOurs/SOTA_SCAmplifier_PNOISE_TB/schematic, simulator spectre
  Models: /esat/micas-data/data/design/generic/045/gpdk045_v_4_0/gpdk045/../models/spectre/gpdk045.scs[mc]
  Variables: A = 2; r_cmfb = 100; B = 2; Cfb = 0.5p; Cin = 5p; Cl = 2.5p; alpha = 0.01; fin = 0; fsw = 80M; Vin = 0; nL = 5; nL1 = 5; nl2 = 5; nl3 = 3; nL7 = 5; nnF4 = 40; nnF5 = 150; npF1 = 181; npF2 = 150; npF6 = 200; npF7 = 170; nnW3 = 20; nnW5 = 20; npW1 = 20; npW2 = 20; npW6 = 20; npW7 = 20; INCM = 0.55; OUTCMRef = 0.55; vdd = 1.1; vb1 = 0.58; vb5 = 0.4; vb6 = 0.29; vb7 = 0.59
  Temperature: 27
  Analysis pss: engine=Shooting fund=80M harms=200
  Analysis pnoise: start=1 stop=VAR("fsw")/2 dec=15 fund=80M noisetype=sampled
  Output Output Noise (V/sqrt(Hz)) = getData("out" ?result "pnoise_sample_pm0")
  Output Integrated Noise (V) = pow(integ(pow(clip(getData("out" ?result "pnoise_sample_pm0") 1 40000000) 2)) 0.5)
  Output v (/VoutP /VoutN); pac mag(V) = (vh('pac "/VoutP") - vh('pac "/VoutN"))
  Signals: /OUTDM
Run mode: Single Run, Sweeps and Corners
