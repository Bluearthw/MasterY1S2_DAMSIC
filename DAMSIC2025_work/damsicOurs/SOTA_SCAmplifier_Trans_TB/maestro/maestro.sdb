ADE simulation setup
Run mode: Single Run, Sweeps and Corners
Tests:
  damsicOurs_SOTA_SCAmplifier_Trans_TB_1: damsicOurs/SOTA_SCAmplifier_Trans_TB/schematic, simulator spectre
    Variables: Cfb = 0.5p; Cin = 5p; Cl = 2.5p; A = 1; r_cmfb = 100; B = 2; alpha = 0.01; fin = 2M; fsw = 80M; Vin = 0.05; nL = 5; nL1 = 5; nl2 = 5; nl3 = 3; nL7 = 5; nnF4 = 30; nnF5 = 140; npF1 = 222; npF2 = 222; npF6 = 170; npF7 = 170; nnW3 = 20; nnW5 = 20; npW1 = 20; npW2 = 20; npW6 = 20; npW7 = 20; INCM = 0.55; OUTCMRef = 0.55; vb1 = 0.55; vb5 = 0.95; vb6 = 0.3; vb7 = 0.35; vdd = 1.1
