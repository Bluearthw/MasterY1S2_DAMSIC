ADE simulation setup
Run mode: Single Run, Sweeps and Corners
Tests:
  damsicOurs_SOTA_Transient_AC_TB_withouthFB_1: damsicOurs/SOTA_Transient_AC_TB_withouthFB/schematic, simulator spectre
    Variables: B = 1; Cl = 2.5p; FreqIn = 1k; INDM = 0.05; nL = 5; nL1 = 5; nl2 = 5; nl3 = 5; nL7 = 5; npW1 = 20; npW2 = 20; npW6 = 20; npW7 = 20; npW_inputPair = 20; nW = 20; vb1 = 0.55; vb5 = 0.95; vb6 = 0.3; vb7 = 0.35; vdd = 1.1; INCM = 0.35; OUTCMREF = 0.435; nnF = 106; nnF3 = 106; nnF4 = 106; npF = 106; npF1 = 212; npF2 = 106; npF6 = 106; npF7 = 106
