ADE simulation setup
Run mode: Single Run, Sweeps and Corners
Tests:
  damsicOurs_GBOTA_Ideal_withoutCMFB_1: damsicOurs/GBOTA_Ideal_withoutCMFB/schematic, simulator spectre
    Variables: B = 2; gm_GB = 10m; ro_GB = 1M; nL = 5; nL1 = 5; nl2 = 5; nl3 = 3; nL7 = 5; nnF4 = 30; nnF5 = 140; npF1 = 222; npF2 = 222; npF6 = 170; npF7 = 170; npW1 = 20; npW2 = 20; npW6 = 20; npW7 = 20; nnW3 = 20; nnW5 = 20
