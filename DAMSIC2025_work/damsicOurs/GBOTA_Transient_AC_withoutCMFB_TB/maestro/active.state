ADE simulation setup
Test damsicOurs_GBOTA_Transient_AC_withoutCMFB_TB_1: damsicOurs/GBOTA_Transient_AC_withoutCMFB_TB/schematic, simulator spectre
  Models: /esat/micas-data/data/design/generic/045/gpdk045_v_4_0/gpdk045/../models/spectre/gpdk045.scs[mc]
  Variables: B = 2; Cl = 2.5p; FreqIn = 1k; gm_GB = 10m; ro_GB = 1k; INDM = 0.05; nL = 5; nL1 = 5; nl2 = 5; nl3 = 3; nL7 = 10; nnF4 = 30; nnF5 = 140; npF1 = 222; npF2 = 222; npF6 = 170; npF7 = 17; npW1 = 20; npW2 = 20; npW6 = 20; npW7 = 20; nnW3 = 20; nnW5 = 20; INCM = 0.35; vb1 = 0.55; vb5 = 0.85; vb6 = 0.5; vdd = 1.1
  Temperature: 27
  Analysis dc: (saves the operating point)
Run mode: Single Run, Sweeps and Corners
