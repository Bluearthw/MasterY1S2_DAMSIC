ADE simulation setup
Test damsicOurs_FCOTA_Transient_AC_TB_NMOSIN_1: damsicOurs/FCOTA_Transient_AC_TB_NMOSIN/schematic, simulator spectre
  Models: /esat/micas-data/data/design/generic/045/gpdk045_v_4_0/gpdk045/../models/spectre/gpdk045.scs[mc]
  Variables: A = 4; r_cmfb = 200; Cl = 2.5p; FreqIn = 1k; INDM = 0.05; nL1 = 6; nl2 = 9; nl3 = 9; nL5 = 9; nL6 = 9; nL7 = 3; nnF3 = 213; nnF5 = 213; npF1 = 53; npF2 = 88; npF6 = 203; npF7 = 53; npW1 = 20; npW2 = 20; npW6 = 20; npW7 = 20; nnW3 = 20; nnW5 = 20; INCM = 0.84; OUTCMREF = 0.3; vb1 = 0.613; vb3 = 0.49; vb5 = 0.64; vb6 = 0.2; vb7 = 0.47; vdd = 1.1
  Temperature: 27
  Analysis ac: start=1 stop=10G dec=15
  Analysis dc: (saves the operating point)
  Output v /OUTDM; ac dB20(V) = db(vfreq('ac "/OUTDM"))
  Output v /OUTDM; ac deg(V) = phaseDegUnwrapped(vfreq('ac "/OUTDM"))
Run mode: Single Run, Sweeps and Corners
