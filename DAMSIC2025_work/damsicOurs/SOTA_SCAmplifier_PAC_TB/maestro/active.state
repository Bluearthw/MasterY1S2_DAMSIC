ADE simulation setup
Test damsicOurs_GBOTA_SCAmplifier_PAC_TB_1: damsicOurs/GBOTA_SCAmplifier_PAC_TB/schematic, simulator spectre
  Models: /esat/micas-data/data/design/generic/045/gpdk045_v_4_0/gpdk045/../models/spectre/gpdk045.scs[mc]
  Variables: A = 2; r_cmfb = 100; B = 2; Cl = 2.5p; Cfb = 0.5p; Cin = 5.14p; FreqIn = 1k; gm_GB = 10m; ro_GB = 10k; OUTCMRef = 0.55; INDM = 0.05; nL = 5; nL1 = 5; nl2 = 5; nl3 = 3; nL7 = 5; nnF4 = 40; nnF5 = 150; npF1 = 181; npF2 = 190; npF6 = 200; npF7 = 170; npW1 = 20; npW2 = 20; npW6 = 20; npW7 = 20; nnW3 = 20; nnW5 = 20; INCM = 0.55; OUTCMREF = 0.55; vb1 = 0.58; vb5 = 0.84; vb6 = 0.29; vb7 = 0.59; vdd = 1.1; GB1_nL1 = 6; GB1_nl2 = 5; GB1_nL3 = 3; GB1_nL5 = 5; GB1_nL6 = 4; GB1_nL7 = 4; GB1_nnF3 = 52; GB1_nnF5 = 150; GB1_npF1 = 100; GB1_npF2 = 199; GB1_npF6 = 222; GB1_npF7 = 222; GB1_nnW3 = 20; GB1_nnW5 = 20; GB1_npW1 = 20; GB1_npW2 = 20; GB1_npW6 = 20; GB1_npW7 = 20; GB1_A = 3; GB1_Cl = 5p; GB1_r_cmfb = 200; GB1_vb1 = 0.52; GB1_vb3 = 0.59; GB1_vb5 = 0.82; GB1_vb6 = 0.52; GB1_vb7 = 0.6; GB2_A = 3; GB2_r_cmfb = 200; GB2_Cl = 5p; GB2_nL1 = 6; GB2_nl2 = 9; GB2_nl3 = 9; GB2_nL5 = 9; GB2_nL6 = 9; GB2_nL7 = 3; GB2_nnF3 = 213; GB2_nnF5 = 263; GB2_npF1 = 53; GB2_npF2 = 88; GB2_npF6 = 203; GB2_npF7 = 53; GB2_nnW3 = 20; GB2_nnW5 = 20; GB2_npW1 = 20; GB2_npW2 = 20; GB2_npW6 = 20; GB2_npW7 = 20; GB2_vb1 = 0.613; GB2_vb3 = 0.45; GB2_vb5 = 0.65; GB2_vb6 = 0.21; GB2_vb7 = 0.47; alpha = 0.01; fsw = 80M; RSW_OFF = 100M*10; RSW_ON = 10; Vmax = 50m; Vmin = 25m; VSW_TH = 0.55; fin = 2M; Vin = 0
  Temperature: 27
  Analysis pac: start=1 stop=VAR("fsw")/2 dec=50 fund=VAR("fsw")
  Analysis pss: engine=Shooting fund=VAR("fsw") harms=200
  Output vtime('pss "/phi<2>")
  Output (vh('pac "/VoutP") - vh('pac "/VoutN"))
Run mode: Single Run, Sweeps and Corners
