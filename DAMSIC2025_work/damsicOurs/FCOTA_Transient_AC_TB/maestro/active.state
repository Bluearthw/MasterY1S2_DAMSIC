ADE simulation setup
Test damsicOurs_FCOTA_Transient_AC_TB_1: damsicOurs/FCOTA_Transient_AC_TB/schematic, simulator spectre
  Models: /esat/micas-data/data/design/generic/045/gpdk045_v_4_0/gpdk045/../models/spectre/gpdk045.scs[mc]
  Variables: A = 3; r_cmfb = 200; Cl = 2.5p; FreqIn = 1k; INDM = 0.05; nL1 = 6; nl2 = 5; nl3 = 3; nL5 = 5; nL6 = 4; nL7 = 4; nnF3 = 52; nnF5 = 150; npF1 = 100; npF2 = 199; npF6 = 222; npF7 = 222; npW1 = 20; npW2 = 20; npW6 = 20; npW7 = 20; nnW3 = 20; nnW5 = 20; INCM = 0.28; OUTCMREF = 0.84; vb1 = 0.52; vb3 = 0.59; vb5 = 0.82; vb6 = 0.52; vb7 = 0.6; vdd = 1.1; vth = "OP(\"I21/NM3r\" \"vth\")"
  Temperature: 27
  Analysis dc: (saves the operating point)
  Analysis ac: start=1 stop=10G dec=20
  Output v /OUTDM; ac dB20(V) = db(vfreq('ac "/OUTDM"))
  Output v /OUTDM; ac deg(V) = phaseDegUnwrapped(vfreq('ac "/OUTDM")) (unticked)
Run mode: Single Run, Sweeps and Corners
Setup values for test damsicOurs_FCOTA_Transient_AC_TB_1: vth = OP("I21/NM3r" "vth")
