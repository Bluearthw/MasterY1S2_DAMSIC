ADE simulation setup
Run mode: Single Run, Sweeps and Corners
Tests:
  DAMSIC25_TB_POS_FEB_IDEAL_TB_1: SESSION_1_EXCERCISE/POS_FEB_IDEAL_TB/schematic, simulator spectre
    Variables: tdelay = 10ps
