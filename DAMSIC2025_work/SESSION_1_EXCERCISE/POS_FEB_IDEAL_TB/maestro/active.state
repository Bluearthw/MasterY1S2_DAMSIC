ADE simulation setup
Test DAMSIC25_TB_POS_FEB_IDEAL_TB_1: SESSION_1_EXCERCISE/POS_FEB_IDEAL_TB/schematic, simulator spectre
  Models: /esat/micas-data/data/design/generic/045/gpdk045_v_4_0/gpdk045/../models/spectre/gpdk045.scs[mc]
  Variables: tdelay = 10ps
  Temperature: 27
  Analysis tran: stop=5u errpreset=conservative maxstep=10p
  Signals: /IN, /OUT
Run mode: Single Run, Sweeps and Corners
